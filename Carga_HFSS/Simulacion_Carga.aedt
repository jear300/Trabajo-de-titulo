# Ansys Electronics Desktop project, version 2018.1
materials:
  vacuum: permittivity=1
  copper: permeability=0.999991 conductivity=58000000
  MF-124: permittivity=23 dielectric_loss_tangent=0.004 magnetic_loss_tangent=2.5 delta_H_freq=42500000000
  air: permittivity=1.0006 permeability=1.0000004

design HFSSDesign1 (HFSS, DrivenModal, model units mm)
options: Calculate_Lossy_Dielectrics
variables:
  a_guia = 2.54mm
  l_guia = (5  + 2 * ajuste_posy/1mm) mm
  grosor = 0.95
  b = 5.0456912mm
  delta_carga = 1mm
  largo_carga = 1.3mm
  rot_carga = 15deg
  ancho_carga = 20mm
  z_carga = 20mm
  b_guia = 1.27mm
  zpos_carga = 0mm
  ajuste_posy = (b_guia/2 mm)/tan(rot_carga) mm
  tamano_extra = 0mm
  number_duplicate = 0
geometry:
  coordinate_system eje_carga = origin=(-b_guia/2, 0mm, 0mm) x=(1mm, 0mm, 0mm) y=(0mm, 1mm, 0mm)
  Carga [MF-124] = box(corner=(-tamano_extra/2, -a_guia/2 - tamano_extra/2, ((-b_guia/2)/sin(rot_carga)) - tamano_extra/2), size=(largo_carga + tamano_extra, a_guia + tamano_extra, (b_guia/ sin(rot_carga)) + tamano_extra)) in eje_carga
  Carga.rotate(axis=Y, angle=rot_carga) in eje_carga
  Box3 = box(corner=(-a_guia/2, -a_guia/2, 0mm), size=(b_guia, a_guia, l_guia))
  Air [air] = Box3.copy()
  Box3.delete()
  Carga.move(0mm, 0mm, ajuste_posy) in eje_carga
  Carga_1 = Carga.copy()
  Air.subtract(Carga_1)
  Carga1 = box(corner=(0mm, -a_guia/2, ((-b_guia/2)/sin(rot_carga))), size=(largo_carga, a_guia, (b_guia/ sin(rot_carga)))) in eje_carga
  Carga1.rotate(axis=Y, angle=rot_carga) in eje_carga
  Carga1.move(0mm, 0mm, ajuste_posy) in eje_carga
  Air.unite(Carga1)
  Carga_2 = Carga.copy()
  Air.subtract(Carga_2)
  Carga.duplicate_along_line(step=(0mm, 4mm, 0mm), total=number_duplicate, attached)
boundaries and excitations:
  port1: Wave Port Faces=Air.face(1 of 6) NumModes=1 Modes{Mode1{CharImp=Zpi}}
setups:
  Setup1: HfssDriven Frequency=91.5GHz MaxDeltaS=0.02 MaximumPasses=6 MinimumPasses=1 MinimumConvergedPasses=1 PercentRefinement=30 BasisOrder=1 PortAccuracy=2
    sweep Sweep1: 67GHz to 116GHz step 1GHz; Type=Fast SaveFields
source amplitudes:
  port1:1: 1W 0deg
optimetrics:
  ParametricSetup1: Parametric disabled Sim._Setups=[Setup1]
    sweep rot_carga: LIN 10deg 60deg 5deg
  ParametricSetup2: Parametric disabled Sim._Setups=[Setup1]
    sweep tamano_extra: LIN -1mm -0.01mm 0.04mm
reports:
  S Parameter Plot 1: dB(S(port1,port1)) vs Freq on Setup1 : Sweep1
  S Parameter Plot 2: dB(S(port1,port1)) vs Freq on Setup1 : Sweep1 [rot_carga=all]
  S Parameter Plot 3: dB(S(port1,port1)) vs Freq on Setup1 : Sweep1 [tamano_extra=all]
